.DATA param_data R_LOAD
+ 100
+ 1k
+ 10k
+ 100k
+ 1000k
.ENDDATA
