* Parameter Data Block for Temperature Sweep
.DATA param_data TEMP
-40
0
25
85
125
.ENDDATA
