* Analysis - Static Power
VIN IN VSS DC 0V

.dc VIN 'VSS_VAL' 'VDD_VAL' 'VDD_VAL'

* Print supply current at static voltage levels

.print dc I(VDD)
