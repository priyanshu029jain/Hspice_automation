* Slow NMOS, Slow PMOS (Higher Vth magnitude, lower mobility)
.PARAM VTH_OFFSET_N = 0.05
.PARAM VTH_OFFSET_P = -0.05
.PARAM UTE_N_VAL     = -1.7
.PARAM UTE_P_VAL     = -1.7
