.DATA param_data L_mos
+ 65N
+ 90N
+ 130N
+ 180N
.ENDDATA
