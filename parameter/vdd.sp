.DATA param_data VDD_VAL
+ 0.6V
+ 0.7v
+ 0.8V
+ 0.9V
+ 1.0V
+ 1.2V
+ 1.4V
+ 1.7V
.ENDDATA
