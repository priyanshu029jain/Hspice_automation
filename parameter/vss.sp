.DATA param_data VSS_VAL
+ 0.0V
+ 0.05V
+ 0.10V
+ 0.15V
.ENDDATA
