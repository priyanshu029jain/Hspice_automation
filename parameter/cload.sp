.DATA param_data Cload
+ 1fF
+ 2ff
+ 3fF
+ 5ff
+ 10ff
+ 20ff
+ 30ff
+ 100ff
+ 300ff
+ 500ff
+ 800ff
.ENDDATA
