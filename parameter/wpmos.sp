.DATA param_data W_pmos
+ 65N
+ 130N
+ 195N
+ 260N
.ENDDATA
