.DATA param_data W_nmos
+ 65N
+ 130N
+ 195N
+ 260N
.ENDDATA
