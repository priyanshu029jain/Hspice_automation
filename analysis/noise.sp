* analysis/noise.sp - Noise Analysis
VIN IN VSS DC 0.5V AC 1V

.ac dec 10 1k 100G
.noise V(OUT) VIN 10
